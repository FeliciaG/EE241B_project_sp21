ADE simulation setup
Run mode: Single Run, Sweeps and Corners
Tests:
  project:strongARM_tb2:1: project/strongARM_tb2/schematic, simulator spectre
Global variables:
  fclk = 250K
  vdd = {Inclusion List}500m{Inclusion List}{Inclusion List}900m{Inclusion List}
