ADE simulation setup
Run mode: Single Run, Sweeps and Corners
Tests:
  project:strongARM_tb:1: project/strongARM_tb/schematic, simulator spectre
Global variables:
  vdd = {Inclusion List}0.63, 0.7, 0.77{Inclusion List}
  vg = 0
