ADE simulation setup
Run mode: Single Run, Sweeps and Corners
Tests:
  project:strongARM_tb:1: project/strongARM_tb/schematic, simulator spectre
Global variables:
  fclk = 250k
  vdd = {Inclusion List}0.5{Inclusion List}{Inclusion List}0.9{Inclusion List}
  vg = 0
