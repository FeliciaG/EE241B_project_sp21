// Design: project/strongARM_tb
simulator lang=spectre
global 0
parameters vdd=0.63 vg=0
include "/home/ff/ee241/spring21-labs/asap7PDK_r1p5/models/hspice/7nm_TT.pm"

// project/strongARM_alib/schematic
subckt strongARM_alib CLK GND VDD Vin1 Vin2 outn outp
    M10 (net23 CLK VDD VDD) pmos_rvt w=27n l=20n
    M9 (outp CLK VDD VDD) pmos_rvt w=27n l=20n
    M8 (net19 CLK VDD VDD) pmos_rvt w=27n l=20n
    M7 (outn CLK VDD VDD) pmos_rvt w=27n l=20n
    M6 (outp outn VDD VDD) pmos_rvt w=27n l=20n
    M5 (outn outp VDD VDD) pmos_rvt w=27n l=20n
    M4 (outn outp net19 GND) nmos_rvt w=81n l=20n
    M3 (outp outn net23 GND) nmos_rvt w=81n l=20n
    M2 (net18 CLK GND GND) nmos_rvt w=162n l=20n
    M1 (net19 Vin2 net18 GND) nmos_rvt w=81n l=20n
    M0 (net23 Vin1 net18 GND) nmos_rvt w=81n l=20n
ends strongARM_alib

// project/strongARM_tb/schematic
V0 (net1 0) vsource dc=vdd type=dc
V3 (Vin2 0) vsource type=pulse val0=vdd/2 val1=vdd/2 period=1 delay=3u
V2 (Vin1 0) vsource type=pulse val0=vdd/2 val1=vdd/2 period=8u delay=5u
V1 (CLK 0) vsource type=pulse val0=0 val1=vdd period=4u delay=2u
I0 (CLK 0 net1 Vin1 Vin2 outn outp) strongARM_alib
simulatorOptions options temp=27
dcOp dc
dc dc param=vg start=0 stop=0.7
tran tran stop=10m errpreset=liberal noisefmax=6G noiseseed=1
save outn outp CLK Vin1 Vin2 V0:p
